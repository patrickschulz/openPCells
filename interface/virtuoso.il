/*
 * This file provides a template on how to read the points generated by the script
 * The procedure is easy:
 *  - call the script with the virtuoso interface
 *  - it will write all points to a file
 *  - the location of the file can be read from the process with ipcReadProcess
 *  - iterate over all lines in the written file to get the points
 */
let(
	(
        (path "/home/pschulz/path/cells")
        (cell "transistor")
        ;(cell "momcap")
        command pid filename file
        state lpp pts
    )
    command = lsprintf("lua %s/%s.lua" path cell)
	pid = ipcBeginProcess(command)
	ipcWait(pid) ; wait for process to finish
	filename = ipcReadProcess(pid)
	println(filename)
	file = infile(filename)
	state = "header"
	when(file
	    while(line = gets(nil file)
	    	printf("line: %s" line)
	    	if(line == "\n"
	    		then
	    			printf("end: %s" line)
		    		state = "endshape"
					dbCreatePolygon(geGetEditCellView() lpp pts)
					pts = nil ; reset points
					state = "header"
				else
			    	when(state == "points"
			    		printf("point: %s" line)
			    		pts = cons(linereadstring(line) pts)
			    	)
			    	when(state == "header"
			    		printf("header: %s" line)
			    		lpp = parseString(line)
			    		state = "points"
			    	)
	    	)
	    )
	)
)
