/*
 * This file provides a template on how to read the points generated by the script
 * The procedure is easy:
 *  - call the script with the virtuoso interface
 *  - it well write all points to a file
 *  - the location of the file can be read from the process with ipcReadProcess
 *  - iterate over all lines to get the points
 */
path = "/home/pschulz/path"
command = lsprintf("lua %f/main.lua %f %f %f %f %f" path R r width sep grid)
pid = ipcBeginProcess(command)
ipcWait(pid)
filename = ipcReadProcess(pid)
file = infile(filename)
when(file
    while(line = lineread(file)
        pts = cons(line pts)
    )
)
dbCreatePolygon(geGetEditCellView() list(layer "drawing") pts)
