procedure(OPCFillWriteInitial(file)
    fprintf(file "%s\n" "-- cell shapes for excludes")
    fprintf(file "%s\n" "local cellshapes = pcell.create_layout_from_script(\"openPCells_cellshapes.lua\")")
    newline(file)
    fprintf(file "%s\n" "-- layers which are going to be filled")
    fprintf(file "%s\n" "local filllayers = { generics.metal(1), generics.metal(2), generics.metal(3) }")
    newline(file)
    fprintf(file "%s\n" "-- assemble excludes")
    fprintf(file "%s\n" "local offsets = {")
    fprintf(file "%s\n" "    [generics.metal(1)] = 500,")
    fprintf(file "%s\n" "    [generics.metal(2)] = 500,")
    fprintf(file "%s\n" "    [generics.metal(3)] = 800,")
    fprintf(file "%s\n" "}")
    fprintf(file "%s\n" "local excludes = {}")
    fprintf(file "%s\n" "for _, layer in ipairs(filllayers) do")
    fprintf(file "%s\n" "    excludes[layer] = {}")
    fprintf(file "%s\n" "    for _, e in ipairs(cellshapes:get_shape_outlines(layer)) do")
    fprintf(file "%s\n" "        local offset = offsets[layer]")
    fprintf(file "%s\n" "        local p = util.offset_polygon(e, offset)")
    fprintf(file "%s\n" "        table.insert(excludes[layer], p)")
    fprintf(file "%s\n" "    end")
    fprintf(file "%s\n" "end")
    newline(file)
    fprintf(file "%s\n" "-- target area")
    fprintf(file "%s\n" "-- can also be non-rectangular")
    fprintf(file "%s\n" "local targetarea = util.rectangle_to_polygon(")
    fprintf(file "%s\n" "    point.create(-10000, -10000),")
    fprintf(file "%s\n" "    point.create( 10000,  10000)")
    fprintf(file "%s\n" ")")
    newline(file)
    fprintf(file "%s\n" "-- main fill cell")
    fprintf(file "%s\n" "local fillcell = object.create(\"fillcell\")")
    newline(file)
    fprintf(file "%s\n" "-- annotate fill excludes")
    fprintf(file "%s\n" "for _, layer in ipairs(filllayers) do")
    fprintf(file "%s\n" "    for _, boundary in ipairs(excludes[layer]) do")
    fprintf(file "%s\n" "        geometry.polygon(fillcell, generics.special(), boundary)")
    fprintf(file "%s\n" "    end")
    fprintf(file "%s\n" "end")
    newline(file)
    fprintf(file "%s\n" "-- sizes for the fill shapes")
    fprintf(file "%s\n" "local fillsizes = {")
    fprintf(file "%s\n" "    [generics.metal(1)] = {")
    fprintf(file "%s\n" "        width = 100,")
    fprintf(file "%s\n" "        height = 100,")
    fprintf(file "%s\n" "        xspace = 100,")
    fprintf(file "%s\n" "        yspace = 100,")
    fprintf(file "%s\n" "    },")
    fprintf(file "%s\n" "    [generics.metal(2)] = {")
    fprintf(file "%s\n" "        width = 100,")
    fprintf(file "%s\n" "        height = 100,")
    fprintf(file "%s\n" "        xspace = 100,")
    fprintf(file "%s\n" "        yspace = 100,")
    fprintf(file "%s\n" "    },")
    fprintf(file "%s\n" "    [generics.metal(3)] = {")
    fprintf(file "%s\n" "        width = 200,")
    fprintf(file "%s\n" "        height = 200,")
    fprintf(file "%s\n" "        xspace = 200,")
    fprintf(file "%s\n" "        yspace = 200,")
    fprintf(file "%s\n" "    },")
    fprintf(file "%s\n" "}")
    newline(file)
    fprintf(file "%s\n" "-- collect the shape outlines from the cell")
    fprintf(file "%s\n" "local excludes = cellshapes:get_shape_outlines(generics.metal(1))")
    fprintf(file "%s\n" "-- add an offset (spacing)")
    fprintf(file "%s\n" "local exclude_offset = 200")
    fprintf(file "%s\n" "for i = 1, #excludes do")
    fprintf(file "%s\n" "    local exclude = excludes[i]")
    fprintf(file "%s\n" "    local new = util.offset_polygon(exclude, exclude_offset)")
    fprintf(file "%s\n" "    excludes[i] = new")
    fprintf(file "%s\n" "end")
    newline(file)
    fprintf(file "%s\n" "-- show the excludes in the layout")
    fprintf(file "%s\n" "for i = 1, #excludes do")
    fprintf(file "%s\n" "    geometry.polygon(fillcell, generics.special(), excludes[i])")
    fprintf(file "%s\n" "end")
    newline(file)
    fprintf(file "%s\n" "-- create fill shapes")
    fprintf(file "%s\n" "for _, layer in ipairs(filllayers) do")
    fprintf(file "%s\n" "    local size = fillsizes[layer]")
    fprintf(file "%s\n" "    geometry.rectangle_fill_in_boundary(fillcell, layer,")
    fprintf(file "%s\n" "        size.width, size.height, -- width/height")
    fprintf(file "%s\n" "        size.width + size.xspace, size.height + size.yspace, -- xpitch/ypitch")
    fprintf(file "%s\n" "        0, 0, -- start offsets (x/y)")
    fprintf(file "%s\n" "        targetarea, -- target area")
    fprintf(file "%s\n" "        excludes[layer] -- table with exclusion polygons")
    fprintf(file "%s\n" "    )")
    fprintf(file "%s\n" "end")
    newline(file)
    fprintf(file "%s\n" "return fillcell")
)

procedure(OPCFillEditScript()
    letseq(
        (
            (cv geGetEditCellView())
            (libPath cv->lib->readPath)
            (cellName cv->cellName)
            path file
        )
        path = lsprintf("%s/%s/layout/opcfill.lua" libPath cellName)
        unless(isFile(path)
            ; add some starting code to empty fill scripts
            file = outfile(path "w")
            OPCFillWriteInitial(file)
            close(file)
        )
        OPCOpenEditor(path)
    )
) ; procedure

procedure(OPCUpdateFillCallback(@key (deleteAll t) (callopc t) (hierarchical nil) (origin list(0 0)) (useOrigin nil))
    letseq(
        (
            (cv geGetEditCellView())
            (libPath cv->lib->readPath)
            (libname cv->libName) ; read by generated .il script, don't remove
            (cellName cv->cellName)
            path groupname OPCArgs OPCCmd success
        )
        ; write out current cell (for exclude shapes)
        OPCExportCell("openPCells_cellshapes.lua")
        ; call fill script
        path = lsprintf("%s/%s/layout/opcfill.lua" libPath cellName)
        groupname = "opcfill"
        OPCArgs = OPCPrepareArgsForCellCreation(
            lsprintf("--cellscript %s -f %s" path OPCSettingsForm->OPCCellFilename->value)
            origin
            ?groupname groupname
        )
        ; FIXME: should fill always be flat? Currently it is, as the callback is called without parameters and hierarchical is nil
        unless(hierarchical
            OPCArgs = lsprintf("%s --flat" OPCArgs)
        )
        OPCCmd = OPCBuildCallCommand(OPCArgs)
        success = if(callopc
            then
                OPCCall(OPCCmd ?redirect OPCSettingsForm->OPCStdoutFileName->value)
            else
                t
        )
        when(success
            let(((group dbGetFigGroupByName(cv groupname)))
                foreach(obj group->figs dbDeleteObject(obj))
            )
            load(lsprintf("%s.il" OPCSettingsForm->OPCCellFilename->value))
            OPCCleanUp(lsprintf("%s.il" OPCSettingsForm->OPCCellFilename->value))
        )
    )
) ; OPCUpdateCellscriptCallback

procedure(OPCDeleteFillScript()
    letseq(
        (
            (cv geGetEditCellView())
            (libPath cv->lib->readPath)
            (cellName cv->cellName)
            (path lsprintf("%s/%s/layout/opcfill.lua" libPath cellName))
        )
        when(isFile(path)
            deleteFile(path)
        )
    )
) ; procedure
