procedure(OPCCreateGuardring()
    let((group properties groupname count)
        properties = list(
            list(nil 'name "opccell" 'type "string" 'value lsprintf("%s" "auxiliary/guardring"))
            list(nil 'name "opcprotect" 'type "boolean" 'value nil)
            list(nil 'name "ringwidth" 'type "float" 'value 0.2)
            list(nil 'name "contype" 'type "string" 'value "n")
            list(nil 'name "holewidth" 'type "float" 'value 5.0)
            list(nil 'name "holeheight" 'type "float" 'value 5.0)
            list(nil 'name "topmetal" 'type "int" 'value 1)
            list(nil 'name "fillwell" 'type "boolean" 'value t)
            list(nil 'name "drawdeepwell" 'type "boolean" 'value nil)
            list(nil 'name "deepwelloffset" 'type "float" 'value 0.0)
            list(nil 'name "fillinnerimplant" 'type "boolean" 'value nil)
            list(nil 'name "innerimplantpolarity" 'type "string" 'value "p")
        )
        count = 1
        groupname = lsprintf("guardring_%d" count)
        while(dbGetFigGroupByName(geGetEditCellView() groupname)
            count = count + 1
            groupname = lsprintf("guardring_%d" count)
        )
        group = OPCSubCellCreateBase(geGetEditCellView() groupname properties)
        OPCSubCellUpdateCell(group)
    )
) ; OPCCreateGuardring

procedure(OPCCreateMosfet()
    let((group properties groupname count success)
        properties = list(
            list(nil 'name "opccell" 'type "string" 'value lsprintf("%s" "basic/mosfet"))
            list(nil 'name "opcprotect" 'type "boolean" 'value nil)
            list(nil 'name "channeltype" 'type "string" 'value "nmos")
            list(nil 'name "oxidetype" 'type "int" 'value 1)
            list(nil 'name "vthtype" 'type "int" 'value 1)
            list(nil 'name "flippedwell" 'type "boolean" 'value nil)
            list(nil 'name "fingers" 'type "int" 'value 4)
            list(nil 'name "fingerwidth" 'type "float" 'value 1.0)
            list(nil 'name "gatelength" 'type "float" 'value 0.1)
            list(nil 'name "gatespace" 'type "float" 'value 0.1)
            list(nil 'name "drawtopgate" 'type "boolean" 'value nil)
            list(nil 'name "drawbotgate" 'type "boolean" 'value nil)
            list(nil 'name "connectsource" 'type "boolean" 'value t)
            list(nil 'name "sourcemetal" 'type "int" 'value 1)
            list(nil 'name "connectdrain" 'type "boolean" 'value t)
            list(nil 'name "drainmetal" 'type "int" 'value 1)
            list(nil 'name "drawguardring" 'type "boolean" 'value nil)
            list(nil 'name "guardringsep" 'type "float" 'value 0)
        )
        count = 1
        groupname = lsprintf("mosfet_%d" count)
        while(dbGetFigGroupByName(geGetEditCellView() groupname)
            count = count + 1
            groupname = lsprintf("mosfet_%d" count)
        )
        group = OPCSubCellCreateBase(geGetEditCellView() groupname properties)
        success = OPCSubCellUpdateCell(group)
        unless(success
            label = dbCreateLabel(geGetEditCellView() OPCGetInfoLayer() 0:0 groupname "centerCenter" "R0" "fixed" 1)
            dbAddFigToFigGroup(group label)
        )
    )
) ; OPCCreateMosfet

procedure(OPCCreateMetalgrid()
    let((group properties groupname count)
        properties = list(
            list(nil 'name "opccell" 'type "string" 'value lsprintf("%s" "auxiliary/metalgrid"))
            list(nil 'name "opcprotect" 'type "boolean" 'value nil)
            list(nil 'name "metalh" 'type "int" 'value 1)
            list(nil 'name "metalv" 'type "int" 'value 2)
            list(nil 'name "drawmetalh" 'type "boolean" 'value t)
            list(nil 'name "drawmetalv" 'type "boolean" 'value t)
            list(nil 'name "mhwidth" 'type "float" 'value 0.500)
            list(nil 'name "mhspace" 'type "float" 'value 0.500)
            list(nil 'name "mvwidth" 'type "float" 'value 0.500)
            list(nil 'name "mvspace" 'type "float" 'value 0.500)
            list(nil 'name "mhlines" 'type "int" 'value 6)
            list(nil 'name "mvlines" 'type "int" 'value 3)
            /*
            list(nil 'name "mvextb" 'type "float" 'value 0)
            list(nil 'name "mvextt" 'type "float" 'value 0)
            list(nil 'name "mhextl" 'type "float" 'value 0)
            list(nil 'name "mhextr" 'type "float" 'value 0)
            list(nil 'name "mvoddextb" 'type "float" 'value 0)
            list(nil 'name "mvoddextt" 'type "float" 'value 0)
            list(nil 'name "mhoddextl" 'type "float" 'value 0)
            list(nil 'name "mhoddextr" 'type "float" 'value 0)
            list(nil 'name "mvevenextb" 'type "float" 'value 0)
            list(nil 'name "mvevenextt" 'type "float" 'value 0)
            list(nil 'name "mhevenextl" 'type "float" 'value 0)
            list(nil 'name "mhevenextr" 'type "float" 'value 0)
            */
            list(nil 'name "drawvias" 'type "boolean" 'value t)
            list(nil 'name "forcevias" 'type "boolean" 'value nil)
            list(nil 'name "continuousvias" 'type "boolean" 'value nil)
            list(nil 'name "centergrid" 'type "boolean" 'value t)
            list(nil 'name "flatvias" 'type "boolean" 'value t)
            list(nil 'name "flipvias" 'type "boolean" 'value nil)
        )
        count = 1
        groupname = lsprintf("metalgrid_%d" count)
        while(dbGetFigGroupByName(geGetEditCellView() groupname)
            count = count + 1
            groupname = lsprintf("metalgrid_%d" count)
        )
        group = OPCSubCellCreateBase(geGetEditCellView() groupname properties)
        OPCSubCellUpdateCell(group)
    )
) ; OPCCreateMetalgrid
