procedure(OPCCreateGuardring()
    let((group properties groupname count)
        properties = list(
            list(nil 'name "opccell" 'type "string" 'value lsprintf("%s" "auxiliary/guardring"))
            list(nil 'name "opcprotect" 'type "boolean" 'value nil)
            list(nil 'name "contype" 'type "string" 'value "n")
            list(nil 'name "holewidth" 'type "float" 'value 5.0)
            list(nil 'name "holeheight" 'type "float" 'value 5.0)
            list(nil 'name "ringwidth" 'type "float" 'value 0.2)
            list(nil 'name "topmetal" 'type "int" 'value 1)
            list(nil 'name "drawmetal" 'type "boolean" 'value t)
            list(nil 'name "wellinnerextension" 'type "float" 'value 0.05)
            list(nil 'name "wellouterextension" 'type "float" 'value 0.05)
            list(nil 'name "soiopeninnerextension" 'type "float" 'value 0.05)
            list(nil 'name "soiopenouterextension" 'type "float" 'value 0.05)
            list(nil 'name "implantinnerextension" 'type "float" 'value 0.05)
            list(nil 'name "implantouterextension" 'type "float" 'value 0.05)
            list(nil 'name "drawsoiopen" 'type "boolean" 'value t)
            list(nil 'name "fillsoiopen" 'type "boolean" 'value nil)
            list(nil 'name "drawimplant" 'type "boolean" 'value t)
            list(nil 'name "fillwell" 'type "boolean" 'value t)
            list(nil 'name "drawdeepwell" 'type "boolean" 'value nil)
            list(nil 'name "deepwelloffset" 'type "float" 'value 0.0)
            list(nil 'name "fillinnerimplant" 'type "boolean" 'value nil)
            list(nil 'name "innerimplantpolarity" 'type "string" 'value "p")
            list(nil 'name "innerimplantspace" 'type "float" 'value 0.0)
        )
        count = 1
        groupname = lsprintf("guardring_%d" count)
        while(dbGetFigGroupByName(geGetEditCellView() groupname)
            count = count + 1
            groupname = lsprintf("guardring_%d" count)
        )
        group = OPCSubCellCreateBase(geGetEditCellView() groupname properties)
        OPCSubCellUpdateCell(group)
    )
)

procedure(OPCCreateMosfet()
    let((group properties groupname count success)
        properties = list(
            list(nil 'name "opccell" 'type "string" 'value lsprintf("%s" "basic/mosfet"))
            list(nil 'name "opcprotect" 'type "boolean" 'value nil)
            list(nil 'name "channeltype" 'type "string" 'value "nmos")
            list(nil 'name "oxidetype" 'type "int" 'value 1)
            list(nil 'name "vthtype" 'type "int" 'value 1)
            list(nil 'name "flippedwell" 'type "boolean" 'value nil)
            list(nil 'name "fingers" 'type "int" 'value 4)
            list(nil 'name "fingerwidth" 'type "float" 'value 1.0)
            list(nil 'name "gatelength" 'type "float" 'value 0.1)
            list(nil 'name "gatespace" 'type "float" 'value 0.1)
            list(nil 'name "actext" 'type "float" 'value 0)
            list(nil 'name "sdwidth" 'type "float" 'value 0)
            list(nil 'name "sdviawidth" 'type "float" 'value 0)
            list(nil 'name "sdmetalwidth" 'type "float" 'value 0)
            list(nil 'name "drawtopgate" 'type "boolean" 'value nil)
            list(nil 'name "drawtopgatestrap" 'type "boolean" 'value nil)
            list(nil 'name "topgatewidth" 'type "float" 'value 0)
            list(nil 'name "topgateleftextension" 'type "float" 'value 0)
            list(nil 'name "topgaterightextension" 'type "float" 'value 0)
            list(nil 'name "topgatespace" 'type "float" 'value 0)
            list(nil 'name "topgatemetal" 'type "int" 'value 1)
            list(nil 'name "drawtopgatevia" 'type "boolean" 'value t)
            list(nil 'name "topgatecontinuousvia" 'type "boolean" 'value nil)
            list(nil 'name "drawbotgate" 'type "boolean" 'value nil)
            list(nil 'name "drawbotgatestrap" 'type "boolean" 'value nil)
            list(nil 'name "botgatewidth" 'type "float" 'value 0)
            list(nil 'name "botgateleftextension" 'type "float" 'value 0)
            list(nil 'name "botgaterightextension" 'type "float" 'value 0)
            list(nil 'name "botgatespace" 'type "float" 'value 0)
            list(nil 'name "botgatemetal" 'type "int" 'value 1)
            list(nil 'name "drawbotgatevia" 'type "boolean" 'value t)
            list(nil 'name "connectsource" 'type "boolean" 'value nil)
            list(nil 'name "drawsourcestrap" 'type "boolean" 'value nil)
            list(nil 'name "drawsourceconnections" 'type "boolean" 'value nil)
            list(nil 'name "connectsourceboth" 'type "boolean" 'value nil)
            list(nil 'name "connectsourcewidth" 'type "float" 'value 0)
            list(nil 'name "connectsourcespace" 'type "float" 'value 0)
            list(nil 'name "connectsourceleftext" 'type "float" 'value 0)
            list(nil 'name "connectsourcerightext" 'type "float" 'value 0)
            list(nil 'name "connectsourceautooddext" 'type "boolean" 'value nil)
            list(nil 'name "connectsourceotherwidth" 'type "float" 'value 0)
            list(nil 'name "connectsourceotherspace" 'type "float" 'value 0)
            list(nil 'name "connectsourceotherleftext" 'type "float" 'value 0)
            list(nil 'name "connectsourceotherrightext" 'type "float" 'value 0)
            list(nil 'name "connectsourceotherautooddext" 'type "boolean" 'value nil)
            list(nil 'name "sourcestartmetal" 'type "int" 'value 1)
            list(nil 'name "sourceendmetal" 'type "int" 'value 1)
            list(nil 'name "sourceviametal" 'type "int" 'value 1)
            list(nil 'name "connectsourceinline" 'type "boolean" 'value nil)
            list(nil 'name "connectsourceinlineoffset" 'type "float" 'value 0)
            list(nil 'name "splitsourcevias" 'type "boolean" 'value nil)
            list(nil 'name "flipsourcedrainstraps" 'type "boolean" 'value nil)
            list(nil 'name "connectsourceinverse" 'type "boolean" 'value nil)
            list(nil 'name "connectdrain" 'type "boolean" 'value nil)
            list(nil 'name "drawdrainstrap" 'type "boolean" 'value nil)
            list(nil 'name "drawdrainconnections" 'type "boolean" 'value nil)
            list(nil 'name "connectdrainboth" 'type "boolean" 'value nil)
            list(nil 'name "connectdrainwidth" 'type "float" 'value 0)
            list(nil 'name "connectdrainspace" 'type "float" 'value 0)
            list(nil 'name "connectdrainleftext" 'type "float" 'value 0)
            list(nil 'name "connectdrainrightext" 'type "float" 'value 0)
            list(nil 'name "connectdrainautooddext" 'type "boolean" 'value nil)
            list(nil 'name "connectdraininverse" 'type "boolean" 'value nil)
            list(nil 'name "connectdrainotherwidth" 'type "float" 'value 0)
            list(nil 'name "connectdrainotherspace" 'type "float" 'value 0)
            list(nil 'name "connectdrainotherleftext" 'type "float" 'value 0)
            list(nil 'name "connectdrainotherrightext" 'type "float" 'value 0)
            list(nil 'name "connectdrainotherautooddext" 'type "boolean" 'value nil)
            list(nil 'name "drawdrainvia" 'type "boolean" 'value t)
            list(nil 'name "drawfirstdrainvia" 'type "boolean" 'value t)
            list(nil 'name "drawlastdrainvia" 'type "boolean" 'value t)
            list(nil 'name "drainstartmetal" 'type "int" 'value 1)
            list(nil 'name "drainendmetal" 'type "int" 'value 1)
            list(nil 'name "drainviametal" 'type "int" 'value 1)
            list(nil 'name "connectdraininline" 'type "boolean" 'value nil)
            list(nil 'name "connectdraininlineoffset" 'type "float" 'value 0)
            list(nil 'name "splitdrainvias" 'type "boolean" 'value nil)
            list(nil 'name "extendoxidetypetop" 'type "float" 'value 0)
            list(nil 'name "extendoxidetypebottom" 'type "float" 'value 0)
            list(nil 'name "extendoxidetypeleft" 'type "float" 'value 0)
            list(nil 'name "extendoxidetyperight" 'type "float" 'value 0)
            list(nil 'name "extendvthtypetop" 'type "float" 'value 0)
            list(nil 'name "extendvthtypebottom" 'type "float" 'value 0)
            list(nil 'name "extendvthtypeleft" 'type "float" 'value 0)
            list(nil 'name "extendvthtyperight" 'type "float" 'value 0)
            list(nil 'name "extendimplanttop" 'type "float" 'value 0)
            list(nil 'name "extendimplantbottom" 'type "float" 'value 0)
            list(nil 'name "extendimplantleft" 'type "float" 'value 0)
            list(nil 'name "extendimplantright" 'type "float" 'value 0)
            list(nil 'name "extendwelltop" 'type "float" 'value 0)
            list(nil 'name "extendwellbottom" 'type "float" 'value 0)
            list(nil 'name "extendwellleft" 'type "float" 'value 0)
            list(nil 'name "extendwellright" 'type "float" 'value 0)
            list(nil 'name "extendlvsmarkertop" 'type "float" 'value 0)
            list(nil 'name "extendlvsmarkerbottom" 'type "float" 'value 0)
            list(nil 'name "extendlvsmarkerleft" 'type "float" 'value 0)
            list(nil 'name "extendlvsmarkerright" 'type "float" 'value 0)
            /*
            list(nil 'name "extendrotationmarkertop" 'type "float" 'value 0)
            list(nil 'name "extendrotationmarkerbottom" 'type "float" 'value 0)
            list(nil 'name "extendrotationmarkerleft" 'type "float" 'value 0)
            list(nil 'name "extendrotationmarkerright" 'type "float" 'value 0)
            list(nil 'name "extendanalogmarkertop" 'type "float" 'value 0)
            list(nil 'name "extendanalogmarkerbottom" 'type "float" 'value 0)
            list(nil 'name "extendanalogmarkerleft" 'type "float" 'value 0)
            list(nil 'name "extendanalogmarkerright" 'type "float" 'value 0)
            */
            list(nil 'name "drawguardring" 'type "boolean" 'value nil)
            list(nil 'name "guardringrespectactivedummy" 'type "boolean" 'value nil)
            list(nil 'name "guardringwidth" 'type "float" 'value 0)
            list(nil 'name "guardringleftsep" 'type "float" 'value 0)
            list(nil 'name "guardringrightsep" 'type "float" 'value 0)
            list(nil 'name "guardringtopsep" 'type "float" 'value 0)
            list(nil 'name "guardringbottomsep" 'type "float" 'value 0)
            ; FIXME: figure out how to use lists as properties (ILList?)
            ;list(nil 'name "guardringsegments" 'type "float" 'value { left,right,top,bottom })
            list(nil 'name "guardringfillimplant" 'type "boolean" 'value nil)
            list(nil 'name "guardringfillwell" 'type "boolean" 'value nil)
            list(nil 'name "guardringwellinnerextension" 'type "float" 'value 0)
            list(nil 'name "guardringwellouterextension" 'type "float" 'value 0)
            list(nil 'name "guardringimplantinnerextension" 'type "float" 'value 0)
            list(nil 'name "guardringimplantouterextension" 'type "float" 'value 0)
            list(nil 'name "guardringsoiopeninnerextension" 'type "float" 'value 0)
            list(nil 'name "guardringsoiopenouterextension" 'type "float" 'value 0)
            /*
list(nil 'name "drawimplant" 'type "boolean" 'value t)
list(nil 'name "implantalignwithactive" 'type "boolean" 'value nil)
list(nil 'name "implantalignleftwithactive" 'type "boolean" 'value nil)
list(nil 'name "implantalignrightwithactive" 'type "boolean" 'value nil)
list(nil 'name "implantaligntopwithactive" 'type "boolean" 'value nil)
list(nil 'name "implantalignbottomwithactive" 'type "boolean" 'value nil)
list(nil 'name "oxidetypealignwithactive" 'type "boolean" 'value nil)
list(nil 'name "oxidetypealignleftwithactive" 'type "boolean" 'value nil)
list(nil 'name "oxidetypealignrightwithactive" 'type "boolean" 'value nil)
list(nil 'name "oxidetypealigntopwithactive" 'type "boolean" 'value nil)
list(nil 'name "oxidetypealignbottomwithactive" 'type "boolean" 'value nil)
list(nil 'name "vthtypealignwithactive" 'type "boolean" 'value nil)
list(nil 'name "vthtypealignleftwithactive" 'type "boolean" 'value nil)
list(nil 'name "vthtypealignrightwithactive" 'type "boolean" 'value nil)
list(nil 'name "vthtypealigntopwithactive" 'type "boolean" 'value nil)
list(nil 'name "vthtypealignbottomwithactive" 'type "boolean" 'value nil)
list(nil 'name "wellalignwithactive" 'type "boolean" 'value nil)
list(nil 'name "wellalignleftwithactive" 'type "boolean" 'value nil)
list(nil 'name "wellalignrightwithactive" 'type "boolean" 'value nil)
list(nil 'name "wellaligntopwithactive" 'type "boolean" 'value nil)
list(nil 'name "wellalignbottomwithactive" 'type "boolean" 'value nil)
list(nil 'name "gatemarker" 'type "float" 'value 1)
list(nil 'name "mosfetmarker" 'type "float" 'value 1)
list(nil 'name "mosfetmarkeralignatsourcedrain" 'type "boolean" 'value nil)
list(nil 'name "interweavevias" 'type "boolean" 'value nil)
list(nil 'name "alternateinterweaving" 'type "boolean" 'value nil)
list(nil 'name "minviaxspace" 'type "float" 'value 0)
list(nil 'name "minviayspace" 'type "float" 'value 0)
list(nil 'name "gtopext" 'type "float" 'value 0)
list(nil 'name "gbotext" 'type "float" 'value 0)
list(nil 'name "gtopextadd" 'type "float" 'value 0)
list(nil 'name "gbotextadd" 'type "float" 'value 0)
list(nil 'name "gatetopabsoluteheight" 'type "float" 'value 0)
list(nil 'name "gatebotabsoluteheight" 'type "float" 'value 0)
list(nil 'name "drawleftstopgate" 'type "boolean" 'value nil)
list(nil 'name "drawrightstopgate" 'type "boolean" 'value nil)
list(nil 'name "endleftwithgate" 'type "boolean" 'value nil)
list(nil 'name "endrightwithgate" 'type "boolean" 'value nil)
list(nil 'name "leftendgatelength" 'type "float" 'value 0)
list(nil 'name "leftendgatespace" 'type "float" 'value 0)
list(nil 'name "rightendgatelength" 'type "float" 'value 0)
list(nil 'name "rightendgatespace" 'type "float" 'value 0)
list(nil 'name "botgatecontinuousvia" 'type "boolean" 'value nil)
list(nil 'name "drawtopgatecut" 'type "boolean" 'value nil)
list(nil 'name "topgatecutheight" 'type "float" 'value 0)
list(nil 'name "topgatecutspace" 'type "float" 'value 0)
list(nil 'name "topgatecutleftext" 'type "float" 'value 0)
list(nil 'name "topgatecutrightext" 'type "float" 'value 0)
list(nil 'name "drawbotgatecut" 'type "boolean" 'value nil)
list(nil 'name "botgatecutheight" 'type "float" 'value 0)
list(nil 'name "botgatecutspace" 'type "float" 'value 0)
list(nil 'name "botgatecutleftext" 'type "float" 'value 0)
list(nil 'name "botgatecutrightext" 'type "float" 'value 0)
list(nil 'name "simulatemissinggatecut" 'type "boolean" 'value nil)
list(nil 'name "drawsourcedrain" 'type "float" 'value both)
list(nil 'name "excludesourcedraincontacts" 'type "float" 'value  )
list(nil 'name "sourcesize" 'type "float" 'value 0)
list(nil 'name "sourceviasize" 'type "float" 'value 0)
list(nil 'name "drainsize" 'type "float" 'value 0)
list(nil 'name "drainviasize" 'type "float" 'value 0)
list(nil 'name "sourcealign" 'type "float" 'value bottom)
list(nil 'name "sourceviaalign" 'type "float" 'value bottom)
list(nil 'name "drainalign" 'type "float" 'value top)
list(nil 'name "drainviaalign" 'type "float" 'value top)
list(nil 'name "drawsourcevia" 'type "boolean" 'value t)
list(nil 'name "drawfirstsourcevia" 'type "boolean" 'value t)
list(nil 'name "drawlastsourcevia" 'type "boolean" 'value t)
list(nil 'name "diodeconnected" 'type "boolean" 'value nil)
list(nil 'name "diodeconnectedreversed" 'type "boolean" 'value nil)
list(nil 'name "drawextrabotstrap" 'type "boolean" 'value nil)
list(nil 'name "extrabotstrapwidth" 'type "float" 'value 0)
list(nil 'name "extrabotstrapspace" 'type "float" 'value 0)
list(nil 'name "extrabotstrapmetal" 'type "float" 'value 1)
list(nil 'name "extrabotstrapleftextension" 'type "float" 'value 0)
list(nil 'name "extrabotstraprightextension" 'type "float" 'value 0)
list(nil 'name "extrabotstrapleftalign" 'type "float" 'value 1)
list(nil 'name "extrabotstraprightalign" 'type "float" 'value 1)
list(nil 'name "drawextratopstrap" 'type "boolean" 'value nil)
list(nil 'name "extratopstrapwidth" 'type "float" 'value 0)
list(nil 'name "extratopstrapspace" 'type "float" 'value 0)
list(nil 'name "extratopstrapmetal" 'type "float" 'value 1)
list(nil 'name "extratopstrapleftextension" 'type "float" 'value 0)
list(nil 'name "extratopstraprightextension" 'type "float" 'value 0)
list(nil 'name "extratopstrapleftalign" 'type "float" 'value 1)
list(nil 'name "extratopstraprightalign" 'type "float" 'value 1)
list(nil 'name "shortdevice" 'type "boolean" 'value nil)
list(nil 'name "shortdeviceleftoffset" 'type "float" 'value 0)
list(nil 'name "shortdevicerightoffset" 'type "float" 'value 0)
list(nil 'name "shortsourcegate" 'type "boolean" 'value nil)
list(nil 'name "shortdraingate" 'type "boolean" 'value nil)
list(nil 'name "shortlocation" 'type "float" 'value inline)
list(nil 'name "shortspace" 'type "float" 'value 0)
list(nil 'name "shortwidth" 'type "float" 'value 0)
list(nil 'name "drawleftactivedummy" 'type "boolean" 'value nil)
list(nil 'name "leftactivedummywidth" 'type "float" 'value 80)
list(nil 'name "leftactivedummyspace" 'type "float" 'value 80)
list(nil 'name "drawrightactivedummy" 'type "boolean" 'value nil)
list(nil 'name "rightactivedummywidth" 'type "float" 'value 80)
list(nil 'name "rightactivedummyspace" 'type "float" 'value 80)
list(nil 'name "drawtopactivedummy" 'type "boolean" 'value nil)
list(nil 'name "topactivedummywidth" 'type "float" 'value 80)
list(nil 'name "topactivedummyspace" 'type "float" 'value 80)
list(nil 'name "drawbottomactivedummy" 'type "boolean" 'value nil)
list(nil 'name "bottomactivedummywidth" 'type "float" 'value 80)
list(nil 'name "bottomactivedummyspace" 'type "float" 'value 80)
list(nil 'name "leftfloatingdummies" 'type "float" 'value 0)
list(nil 'name "rightfloatingdummies" 'type "float" 'value 0)
list(nil 'name "drawactive" 'type "boolean" 'value t)
list(nil 'name "lvsmarker" 'type "float" 'value 1)
list(nil 'name "lvsmarkerincludeguardring" 'type "boolean" 'value t)
list(nil 'name "lvsmarkeralignwithactive" 'type "boolean" 'value nil)
list(nil 'name "drawwell" 'type "boolean" 'value t)
list(nil 'name "drawtopwelltap" 'type "boolean" 'value nil)
list(nil 'name "topwelltapwidth" 'type "float" 'value 0)
list(nil 'name "topwelltapspace" 'type "float" 'value 0)
list(nil 'name "topwelltapextendleft" 'type "float" 'value 0)
list(nil 'name "topwelltapextendright" 'type "float" 'value 0)
list(nil 'name "drawbotwelltap" 'type "boolean" 'value nil)
list(nil 'name "botwelltapwidth" 'type "float" 'value 0)
list(nil 'name "botwelltapspace" 'type "float" 'value 0)
list(nil 'name "botwelltapextendleft" 'type "float" 'value 0)
list(nil 'name "botwelltapextendright" 'type "float" 'value 0)
list(nil 'name "drawstopgatetopgatecut" 'type "boolean" 'value nil)
list(nil 'name "drawstopgatebotgatecut" 'type "boolean" 'value nil)
list(nil 'name "excludestopgatesfromcutregions" 'type "boolean" 'value t)
list(nil 'name "leftpolylines" 'type "float" 'value  )
list(nil 'name "rightpolylines" 'type "float" 'value  )
list(nil 'name "drawrotationmarker" 'type "boolean" 'value nil)
list(nil 'name "drawanalogmarker" 'type "boolean" 'value nil)
*/
        )
        count = 1
        groupname = lsprintf("mosfet_%d" count)
        while(dbGetFigGroupByName(geGetEditCellView() groupname)
            count = count + 1
            groupname = lsprintf("mosfet_%d" count)
        )
        group = OPCSubCellCreateBase(geGetEditCellView() groupname properties)
        success = OPCSubCellUpdateCell(group)
        unless(success
            label = dbCreateLabel(geGetEditCellView() OPCGetInfoLayer() 0:0 groupname "centerCenter" "R0" "fixed" 1)
            dbAddFigToFigGroup(group label)
        )
    )
)

procedure(OPCCreateMetalgrid()
    let((group properties groupname count)
        properties = list(
            list(nil 'name "opccell" 'type "string" 'value lsprintf("%s" "auxiliary/metalgrid"))
            list(nil 'name "opcprotect" 'type "boolean" 'value nil)
            list(nil 'name "metalh" 'type "int" 'value 1)
            list(nil 'name "metalv" 'type "int" 'value 2)
            list(nil 'name "drawmetalh" 'type "boolean" 'value t)
            list(nil 'name "drawmetalv" 'type "boolean" 'value t)
            list(nil 'name "mhwidth" 'type "float" 'value 0.500)
            list(nil 'name "mhspace" 'type "float" 'value 0.500)
            list(nil 'name "mvwidth" 'type "float" 'value 0.500)
            list(nil 'name "mvspace" 'type "float" 'value 0.500)
            list(nil 'name "mhlines" 'type "int" 'value 6)
            list(nil 'name "mvlines" 'type "int" 'value 3)
            /*
            list(nil 'name "mvextb" 'type "float" 'value 0)
            list(nil 'name "mvextt" 'type "float" 'value 0)
            list(nil 'name "mhextl" 'type "float" 'value 0)
            list(nil 'name "mhextr" 'type "float" 'value 0)
            list(nil 'name "mvoddextb" 'type "float" 'value 0)
            list(nil 'name "mvoddextt" 'type "float" 'value 0)
            list(nil 'name "mhoddextl" 'type "float" 'value 0)
            list(nil 'name "mhoddextr" 'type "float" 'value 0)
            list(nil 'name "mvevenextb" 'type "float" 'value 0)
            list(nil 'name "mvevenextt" 'type "float" 'value 0)
            list(nil 'name "mhevenextl" 'type "float" 'value 0)
            list(nil 'name "mhevenextr" 'type "float" 'value 0)
            */
            list(nil 'name "drawvias" 'type "boolean" 'value t)
            list(nil 'name "forcevias" 'type "boolean" 'value nil)
            list(nil 'name "continuousvias" 'type "boolean" 'value nil)
            list(nil 'name "centergrid" 'type "boolean" 'value t)
            list(nil 'name "flatvias" 'type "boolean" 'value t)
            list(nil 'name "flipvias" 'type "boolean" 'value nil)
        )
        count = 1
        groupname = lsprintf("metalgrid_%d" count)
        while(dbGetFigGroupByName(geGetEditCellView() groupname)
            count = count + 1
            groupname = lsprintf("metalgrid_%d" count)
        )
        group = OPCSubCellCreateBase(geGetEditCellView() groupname properties)
        OPCSubCellUpdateCell(group)
    )
)
