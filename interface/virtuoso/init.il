/*
 * This file provides a template on how to read the points generated by the script
 * The procedure is easy:
 *  - call the script with the virtuoso interface
 *  - it will write all points to a file
 *  - the location of the file can be read from the process with ipcReadProcess
 *  - iterate over all lines in the written file to get the points
 */
let(
	(
        (path "/home/pschulz/path/main.lua")
        (cell "transistor")
        ;(cell "momcap")
        args command pid filename file
        state lpp pts exitstatus
    )
    args = lsprintf("%.1f" 1.0)
    command = lsprintf("lua %s %s %s" path cell args)
    println(command)
	pid = ipcBeginProcess(command)
	ipcWait(pid) ; wait for process to finish
	exitstatus = ipcGetExitStatus(pid)
	if(exitstatus != 0
		then
			printf("generator exited with status %d" exitstatus)
		else
			filename = ipcReadProcess(pid)
			println(filename)
			file = infile(filename)
			state = "header"
			when(file
			    while(line = gets(nil file)
			    	if(line == "\n"
			    		then
				    		state = "endshape"
							dbCreatePolygon(geGetEditCellView() lpp pts)
							pts = nil ; reset points
							state = "header"
						else
					    	when(state == "points"
					    		pts = cons(linereadstring(line) pts)
					    	)
					    	when(state == "header"
					    		lpp = parseString(line)
					    		state = "points"
					    	)
			    	)
			    )
			)
	) ; when status
)
