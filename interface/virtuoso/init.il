foreach(
    filename
    list(
        "backup"
        "call"
        "cells"
        "edit_update"
        "export"
        "fill"
        ;"import"
        "menu"
        "misc"
        "powergrid"
        "settings"
        "subcell"
    )
    load(lsprintf("%s/interface/virtuoso/%s.il" OPCPath filename))
)

; initialize forms
unless(boundp('OPCSettingsForm)
    OPCCreateSettingsForm()
)

; set required environment variables
envSetVal("layout" "extractEnabled" 'boolean nil)
envSetVal("layout" "extractKeepShapeAssignment" 'boolean t)
envSetVal("layout" "extractUseAttachedLabelAsConnectivitySources" 'boolean t)
